* fT and device sizing for the IHP SG13G2 npn13G2 HBT
*
* fT is the frequency at which short-circuit current gain h21 falls to unity.
* Two conditions must hold:
*   1. Base driven by a CURRENT source (h21 is a current gain).
*   2. Collector an AC short to ground — satisfied by tying it straight to a
*      DC voltage source, which has zero AC impedance by definition.
*
* AC base current is 1 A, so h21 = ic/ib = ic directly.
*
* Everything below is read out of the AC analysis alone. The first attempt at
* this computed the DC collector current after an `op` and then tried to print
* it after the `ac` — but each analysis creates its own plot, so the variable
* had gone out of scope by then. Instead: h21 at low frequency IS beta, so
* Ic = beta * Ib can be recovered from the same AC sweep with no cross-plot
* reference at all.

.lib /foss/pdks/ihp-sg13g2/libs.tech/ngspice/models/cornerHBT.lib hbt_typ

.param vce=1.0

* collector base emitter substrate — syntax copied from IHP's own testbench
XQ1 c b 0 0 npn13G2 Nx=1 mm_ok=1

VC c 0 DC {vce}
IB 0 b DC 5u AC 1

.control
  set noaskquit
  option gmin=1e-14
  option abstol=1e-15

  echo ""
  echo "  npn13G2, Nx=1, Vce = 1.0 V, 27 C"
  echo ""
  echo "   Ib(uA)     Ic(mA)     beta      fT(GHz)"
  echo "   ----------------------------------------"

  * Numeric values, no unit suffixes, so they can be used in arithmetic.
  * Range stops at 50 uA: beyond that a single-finger device is past its
  * useful current and the solver struggles.
  foreach ibval 5e-7 1e-6 2e-6 3e-6 5e-6 7e-6 1e-5 1.5e-5 2e-5 3e-5 5e-5
    alter IB dc = $ibval
    ac dec 25 1e5 2000g

    let h21db = db(abs(i(VC)))

    * beta = h21 at low frequency, well below any roll-off.
    meas ac h21_lf FIND h21db AT=1e5
    let beta = 10^(h21_lf/20)
    let ic_ma = beta * $ibval * 1000
    let ib_ua = $ibval * 1e6

    meas ac ft when h21db=0 fall=1
    let ft_ghz = ft / 1e9

    echo "   $&ib_ua   $&ic_ma   $&beta   $&ft_ghz"
  end

  echo ""
  echo "  Peak fT sits at low current. Oscillation needs gm, which needs"
  echo "  current, so the VCO will bias well above peak-fT and trade away"
  echo "  headroom there is plenty of. Scale current with Nx, not with"
  echo "  overdriving one finger."
  echo ""

  * ---- device scaling: same current density, more emitter fingers ----
  echo "  Emitter-finger scaling at Ib = 10 uA per device"
  echo ""
  echo "   Nx     Ic(mA)     fT(GHz)"
  echo "   ---------------------------"

  foreach nxval 1 2 4 8
    alter XQ1 Nx = $nxval
    alter IB dc = 1e-5
    ac dec 25 1e5 2000g
    let h21db = db(abs(i(VC)))
    meas ac h21_lf FIND h21db AT=1e5
    let beta = 10^(h21_lf/20)
    let ic_ma = beta * 1e-5 * 1000
    meas ac ft when h21db=0 fall=1
    let ft_ghz = ft / 1e9
    echo "   $nxval    $&ic_ma   $&ft_ghz"
  end

  * ---- one clean h21 curve for plotting ----
  alter XQ1 Nx = 1
  alter IB dc = 5e-6
  ac dec 25 1e5 2000g
  let h21db = db(abs(i(VC)))
  write ft_hbt.raw h21db
  echo ""
  echo "  Wrote ft_hbt.raw (h21 in dB, Nx=1, Ib=5uA).   plot h21db"
.endc

.end
