* VCO with cascode current mirrors and output buffers — IHP SG13G2
*
* THE LAST PLACEHOLDER IS GONE
*
* Every previous run used ideal current sources:
*     ITAIL 2 mA, IB1 4 mA, IB2 4 mA
* Those are now real cascode mirrors, sized in cascode_char.spice:
*     Rref 10 k, Wref 10 um, L = 1 um throughout
*     tail    Wout  70 um -> 1.96 mA, ro 157 kohm, compliance 0.50 V
*     buffers Wout 139 um -> 4.15 mA, ro  76 kohm, compliance 0.51 V
*
* WHY THIS MATTERS MORE THAN THE 2% CURRENT ERROR
*
* Frequency and amplitude will barely move — 1.96 mA against 2 mA is nothing.
* Phase noise is the number at risk, and the reason is specific: a real mirror
* injects drain current noise into the common-mode node, where the switching
* pair upconverts it around the carrier. In many real VCOs the tail is the
* DOMINANT close-in contributor. Every figure measured so far, including the
* -104.3 dBc/Hz at 1 MHz, was taken with that noise source simply absent.
*
* Whatever comes out of this run is the honest number. It may well be worse.
*
* The mirror devices use L = 1 um rather than the 0.13 um the bank switches
* use. Flicker noise goes as 1/(W*L) and the tail's 1/f noise upconverts into
* the 1/f^3 region of the skirt, so length is bought deliberately here. Same
* process, opposite choice from the switches, for a specific reason.
*
* Cascode rather than simple mirror: the tail node swings at 2*f0, and the
* simple mirror's 6.4 kohm let the current modulate with it. The cascode gives
* 157 kohm for 0.5 V of headroom out of the 2.43 V available.
*
.lib /foss/pdks/ihp-sg13g2/libs.tech/ngspice/models/cornerHBT.lib hbt_typ
.lib /foss/pdks/ihp-sg13g2/libs.tech/ngspice/models/cornerMOSlv.lib mos_tt
.lib /foss/pdks/ihp-sg13g2/libs.tech/ngspice/models/cornerMOShv.lib mos_tt

.param vcc    = 3.3
.param itail  = 2m
.param cfix   = 31.6f
.param vtune  = 1.65
.param vgbias = 1.65
.param cc     = 4p
.param rbias  = 10k
.param wsw    = 4u
.param clsb   = 2.08f

* buffer
.param ibuf   = 4m

* cascode mirror sizing (see cascode_char.spice)
.param lm     = 1u
.param wref   = 10u
.param wtail  = 70u
.param wbuf   = 139u
.param rref   = 10k
.param rbb    = 0
.param rload  = 50

.param b0 = 0
.param b1 = 0
.param b2 = 0
.param b3 = 0

VCC vcc 0 DC {vcc}

* ---------------- tank ----------------
L1 vcc n1 0.45n
R1 n1  outp 5.85
L2 vcc n2 0.45n
R2 n2  outn 5.85

CT outp outn {cfix}

* ---------------- varactor, DC-blocked ----------------
CC1 outp gp {cc}
CC2 outn gn {cc}
RB1 gp vg {rbias}
RB2 gn vg {rbias}
VGB vg 0 DC {vgbias}
XCV gp vt gn 0 sg13_hv_svaricap l=0.3u w=3.74u Nx=2 Ny=1 mm_ok=1
VTUNE vt 0 DC {vtune}

* ---------------- 4-bit switched bank ----------------
CB0A outp s0a {2*clsb}
CB0B outn s0b {2*clsb}
XSW0 s0a nb0 s0b 0 sg13_lv_nmos w={wsw} l=0.13u ng=1 m=1
CB1A outp s1a {4*clsb}
CB1B outn s1b {4*clsb}
XSW1 s1a nb1 s1b 0 sg13_lv_nmos w={2*wsw} l=0.13u ng=1 m=1
CB2A outp s2a {8*clsb}
CB2B outn s2b {8*clsb}
XSW2 s2a nb2 s2b 0 sg13_lv_nmos w={4*wsw} l=0.13u ng=1 m=1
CB3A outp s3a {16*clsb}
CB3B outn s3b {16*clsb}
XSW3 s3a nb3 s3b 0 sg13_lv_nmos w={8*wsw} l=0.13u ng=1 m=1

VB0 nb0 0 DC {b0}
VB1 nb1 0 DC {b1}
VB2 nb2 0 DC {b2}
VB3 nb3 0 DC {b3}

RBL0A s0a 0 100k
RBL0B s0b 0 100k
RBL1A s1a 0 100k
RBL1B s1b 0 100k
RBL2A s2a 0 100k
RBL2B s2b 0 100k
RBL3A s3a 0 100k
RBL3B s3b 0 100k

* ---------------- cross-coupled pair ----------------
XQ1 outp outn e 0 npn13G2 Nx=1 mm_ok=1 selft=0
XQ2 outn outp e 0 npn13G2 Nx=1 mm_ok=1 selft=0
* ---------------- cascode mirror reference ----------------
* One reference branch feeds all three output mirrors. nc is the cascode gate
* at 2*Vgs; nb is the mirror gate.
RREF vcc nc {rref}
XMR2 nc nc nb 0 sg13_lv_nmos w={wref} l={lm} ng=1 m=1
XMR1 nb nb 0  0 sg13_lv_nmos w={wref} l={lm} ng=1 m=1

* ---------------- tail current mirror ----------------
XMT2 e  nc ntx 0 sg13_lv_nmos w={wtail} l={lm} ng=1 m=1
XMT1 ntx nb 0   0 sg13_lv_nmos w={wtail} l={lm} ng=1 m=1

* ---------------- output buffers ----------------
* Series base resistors are zero by default. If the tank shows signs of
* instability, or the follower input resistance comes out negative, a few
* ohms here damps it at the cost of a little gain.
RBB1 outp bp {rbb}
RBB2 outn bn {rbb}

XB1 vcc bp ep 0 npn13G2 Nx=2 mm_ok=1
XB2 vcc bn en 0 npn13G2 Nx=2 mm_ok=1
* buffer tail mirrors, one per follower
XMB2A ep  nc nbx1 0 sg13_lv_nmos w={wbuf} l={lm} ng=1 m=1
XMB1A nbx1 nb 0    0 sg13_lv_nmos w={wbuf} l={lm} ng=1 m=1
XMB2B en  nc nbx2 0 sg13_lv_nmos w={wbuf} l={lm} ng=1 m=1
XMB1B nbx2 nb 0    0 sg13_lv_nmos w={wbuf} l={lm} ng=1 m=1

* AC-coupled 50 ohm loads, as a probe or the next stage would present.
CO1 ep lp 1p
CO2 en ln 1p
RL1 lp 0 {rload}
RL2 ln 0 {rload}

* Start from the DC operating point rather than forcing tank voltages. With
* the mirrors present, .ic left their internal nodes inconsistent with the
* forced tank state and the solver could not find a first timestep.
* A short current pulse into one tank node breaks the symmetry instead —
* closer to how real noise starts an oscillator anyway.
*IKICK disabled

.option gmin=1e-11 reltol=1e-2 abstol=1e-10 vntol=1e-5
.option method=gear

.option gmin=1e-11 reltol=1e-2 abstol=1e-10 vntol=1e-5
.option method=gear

.control
  set noaskquit

  echo ""
  echo "  VCO + buffers + cascode mirrors (no ideal sources remain)"
  echo "  Cfix trimmed 36 -> 31.6 fF to absorb the buffer capacitance"
  echo ""
  * Operating point first — confirm the mirrors deliver what they were sized
  * for, and that every device has the headroom it needs.
  op
  let itail_a = -i(vcc)
  let vnc = v(nc)
  let vnb = v(nb)
  let ve  = v(e)
  let vep = v(ep)
  echo "   --- bias check ---"
  echo "   V(nc)   $&vnc V   cascode gate"
  echo "   V(nb)   $&vnb V   mirror gate"
  echo "   V(e)    $&ve V    tail node (needs > 0.50 V compliance)"
  echo "   V(ep)   $&vep V   buffer emitter (needs > 0.51 V)"
  echo "   total supply current $&itail_a A"
  echo ""
  echo "   code   f(GHz)    tank(Vpp)   load(Vpp)"
  echo "   ------------------------------------------"

  foreach code 0 8 15
    let c = $code
    let bit0 = c % 2
    let bit1 = floor(c/2) % 2
    let bit2 = floor(c/4) % 2
    let bit3 = floor(c/8) % 2
    alter VB0 dc = $&bit0 * 3.3
    alter VB1 dc = $&bit1 * 3.3
    alter VB2 dc = $&bit2 * 3.3
    alter VB3 dc = $&bit3 * 3.3
    alter VTUNE dc = 1.65

    tran 0.2p 8n

    let vd = v(outp) - v(outn)
    let vl = v(lp) - v(ln)

    meas tran ta WHEN vd=0 RISE=100
    meas tran tb WHEN vd=0 RISE=110
    meas tran tvx MAX vd FROM=6n TO=8n
    meas tran tvn MIN vd FROM=6n TO=8n
    meas tran lvx MAX vl FROM=6n TO=8n
    meas tran lvn MIN vl FROM=6n TO=8n
    destroy tran1
  end

  echo ""
  echo "  Per code: ta/tb give frequency = 10/(tb-ta); tvx-tvn is the tank"
  echo "  swing; lvx-lvn is what reaches the 50 ohm load."
  echo ""
  echo "  Compare the tank swing against 1.75 Vpp unbuffered. Any drop is the"
  echo "  buffer's input resistance loading the tank, and it costs phase noise"
  echo "  at 20*log10 of the amplitude ratio."
  echo ""
  echo "  Compare the load swing against 0.671 x tank, which is what the"
  echo "  standalone AC characterisation predicted. A large-signal follower"
  echo "  driving 50 ohm will do worse than the small-signal number."
  echo ""
.endc

.end
