* VCO for LVS — IHP SG13G2
*
* Regenerated from build_layout.py to match what was actually built. The
* previous netlist described the 4-bit bank with 4.16/8.32/16.64/33.28 fF
* capacitors, which the process cannot make: the smallest DRC-clean cmim is
* 10 fF. The bank is now 2-bit with 10 and 20 fF capacitors, and the varactor
* went from Nx=2 to Nx=4 to bridge the wider steps.
*
* SYNTAX NOTES, both learned the hard way
*
* The PDK installs a custom NetlistSpiceReaderDelegate (custom_reader.lvs)
* that intercepts M, C, R, Q, L and D. For those it takes the device model
* from a MODEL= PARAMETER, not from the positional slot standard SPICE uses:
*
*     right:  R1 a b 100k MODEL=rhigh
*     wrong:  R1 a b rhigh 100k        <- model ignored, class lookup fails
*
* And a poly resistor needs THREE nodes, not two — the third is the substrate
* under the poly. Two nodes gives "Poly resistor should have 3 nodes".
*
* Device counts, taken from the layout:
*   2  npn13G2 Nx=1     cross-coupled pair
*   2  npn13G2 Nx=2     output buffers
*   4  cmim              bank, 2 branches x 2 plates
*   1  cmim              fixed tank capacitor
*   2  cmim              coupling capacitors
*   1  SVaricap Nx=4     varactor
*   2  nmos              bank switches
*   2  nmos w=70u        tail mirror
*   2  nmos w=10u        reference branch
*   4  nmos w=139u       buffer mirrors
*   3  rhigh 10k         two gate bias, one reference
*   4  rhigh 100k        bleed resistors
*   1  inductor3         tank, 3 terminals

.subckt vco_20g vcc gnd vt vg nb0 nb1 outbp outbn

* ---- tank inductor ----
* LA and LB are the tank ends, LC the centre tap feeding the supply.
XL1 outp outn vcc inductor3_N2_Do110.59_w6_s3

* ---- fixed tank capacitance ----
CT outp outn 31.6f MODEL=cmim

* ---- varactor, DC-blocked ----
CC1 outp gp 4p MODEL=cmim
CC2 outn gn 4p MODEL=cmim
RB1 gp vg gnd 10k MODEL=rhigh
RB2 gn vg gnd 10k MODEL=rhigh
XCV gp vt gn gnd sg13_hv_svaricap l=0.3u w=3.74u Nx=4 Ny=1

* ---- 2-bit switched capacitor bank ----
* 10 fF is the smallest cmim that passes DRC. The split-capacitor arrangement
* puts two in series either side of the switch, so a 10 fF pair gives a 5 fF
* branch: LSB 5 fF, MSB 10 fF, span 15 fF.
CB0A outp s0a 10f MODEL=cmim
CB0B outn s0b 10f MODEL=cmim
XSW0 s0a nb0 s0b gnd sg13_lv_nmos w=8u l=0.13u ng=2 m=1
CB1A outp s1a 20f MODEL=cmim
CB1B outn s1b 20f MODEL=cmim
XSW1 s1a nb1 s1b gnd sg13_lv_nmos w=16u l=0.13u ng=4 m=1

* Bleed resistors hold the switch nodes at a defined DC level when off.
RBL0A s0a gnd gnd 100k MODEL=rhigh
RBL0B s0b gnd gnd 100k MODEL=rhigh
RBL1A s1a gnd gnd 100k MODEL=rhigh
RBL1B s1b gnd gnd 100k MODEL=rhigh

* ---- cross-coupled pair ----
XQ1 outp outn e gnd npn13G2 Nx=1
XQ2 outn outp e gnd npn13G2 Nx=1

* ---- cascode mirror reference ----
RREF vcc nc gnd 10k MODEL=rhigh
XMR2 nc nc nb gnd sg13_lv_nmos w=10u l=1u ng=2 m=1
XMR1 nb nb gnd gnd sg13_lv_nmos w=10u l=1u ng=2 m=1

* ---- tail mirror ----
XMT2 e nc ntx gnd sg13_lv_nmos w=70u l=1u ng=10 m=1
XMT1 ntx nb gnd gnd sg13_lv_nmos w=70u l=1u ng=10 m=1

* ---- output buffers ----
XB1 vcc outp outbp gnd npn13G2 Nx=2
XB2 vcc outn outbn gnd npn13G2 Nx=2

* ---- buffer tail mirrors ----
XMB2A outbp nc nbx1 gnd sg13_lv_nmos w=139u l=1u ng=20 m=1
XMB1A nbx1 nb gnd gnd sg13_lv_nmos w=139u l=1u ng=20 m=1
XMB2B outbn nc nbx2 gnd sg13_lv_nmos w=139u l=1u ng=20 m=1
XMB1B nbx2 nb gnd gnd sg13_lv_nmos w=139u l=1u ng=20 m=1

.ends vco_20g
