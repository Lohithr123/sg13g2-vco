* VCO for LVS — IHP SG13G2
*
* WHY THIS IS WRITTEN IN PRIMITIVE FORM
*
* The PDK's custom SPICE reader (custom_reader.lvs) intercepts only the
* element letters M, C, R, Q, L and D. Anything written as an X subcircuit
* instance is read as a subcircuit call and never becomes a device — so a
* netlist using "XSW0 ... sg13_lv_nmos" produces a reference circuit whose
* devices have no class at all, and LVS finds no correspondence for anything.
* That looks identical to a broken layout and is very hard to tell apart.
*
* The model is also read differently per element, which is not symmetric:
*
*   R   from a MODEL= PARAMETER      R1 a b 100k MODEL=rhigh
*   C   from the POSITIONAL slot     C1 a b cap_cmim 10f
*   M   positional                   M1 d g s b sg13_lv_nmos w=8u l=0.13u
*   Q   positional                   Q1 c b e s npn13G2
*
* And a poly resistor takes three nodes, the third being the substrate.
*
* Device counts match the extracted layout: 10 MOSFETs, 4 bipolars,
* 7 resistors, 7 capacitors, 1 varactor, 1 inductor.
*
* Net names are uppercase because the reader folds them; the varactor PCell
* names its own terminals G1, G2 and W, and those labels win in the layout.

.subckt vco_20g vcc gnd vt vg nb0 nb1 outbp outbn

* ---- tank inductor ----
* Inductor omitted: the PDK LVS deck has ind_extraction.lvs
* commented out, so the layout extracts no inductor device.
* The tank nodes are left as separate nets.

* ---- fixed tank capacitance ----
CT OUTP OUTN cap_cmim w=4.53u l=4.53u

* ---- varactor, DC-blocked ----
CC1 OUTP G1 cap_cmim w=51.58u l=51.58u
CC2 OUTN G2 cap_cmim w=51.58u l=51.58u
RB1 G1 VG GND 10k MODEL=rhigh w=1u l=7.27u
RB2 G2 VG GND 10k MODEL=rhigh w=1u l=7.27u
CCV G1 vt G2 GND sg13_hv_svaricap w=3.74u l=0.3u Nx=4

* ---- 2-bit switched capacitor bank ----
CB0A OUTP S0A cap_cmim w=2.52u l=2.52u
CB0B OUTN S0B cap_cmim w=2.52u l=2.52u
MSW0 S0A NB0 S0B GND sg13_lv_nmos w=8u l=0.13u ng=2 m=1
CB1A OUTP S1A cap_cmim w=3.59u l=3.59u
CB1B OUTN S1B cap_cmim w=3.59u l=3.59u
MSW1 S1A NB1 S1B GND sg13_lv_nmos w=16u l=0.13u ng=4 m=1

RBL0A S0A GND GND 100k MODEL=rhigh w=1u l=73.73u
RBL0B S0B GND GND 100k MODEL=rhigh w=1u l=73.73u
RBL1A S1A GND GND 100k MODEL=rhigh w=1u l=73.73u
RBL1B S1B GND GND 100k MODEL=rhigh w=1u l=73.73u

* ---- cross-coupled pair ----
QQ1 OUTP OUTN E GND npn13G2 Nx=1
QQ2 OUTN OUTP E GND npn13G2 Nx=1

* ---- cascode mirror reference ----
RREF VCC NC GND 10k MODEL=rhigh w=1u l=7.27u
MMR2 NC NC NB GND sg13_lv_nmos w=10u l=1u ng=2 m=1
MMR1 NB NB GND GND sg13_lv_nmos w=10u l=1u ng=2 m=1

* ---- tail mirror ----
MMT2 E NC NTX GND sg13_lv_nmos w=70u l=1u ng=10 m=1
MMT1 NTX NB GND GND sg13_lv_nmos w=70u l=1u ng=10 m=1

* ---- output buffers ----
QB1 VCC OUTP OUTBP GND npn13G2 Nx=2
QB2 VCC OUTN OUTBN GND npn13G2 Nx=2

* ---- buffer tail mirrors ----
MMB2A OUTBP NC NBX1 GND sg13_lv_nmos w=139u l=1u ng=20 m=1
MMB1A NBX1 NB GND GND sg13_lv_nmos w=139u l=1u ng=20 m=1
MMB2B OUTBN NC NBX2 GND sg13_lv_nmos w=139u l=1u ng=20 m=1
MMB1B NBX2 NB GND GND sg13_lv_nmos w=139u l=1u ng=20 m=1

.ends vco_20g
