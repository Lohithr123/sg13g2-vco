* Cross-coupled LC VCO — IHP SG13G2, 20 GHz target
*
* Every component value here comes from earlier simulation on this PDK:
*
*   npn13G2   peak fT 415 GHz at Ic ~ 1.8 mA; high-injection cliff above 4 mA
*   tank L    0.45 nH differential, Q = 6.8 at 20 GHz (openEMS/Palace extracted,
*             geometry N=2 w=4um s=3um do=73.59um)
*   varactor  22.6-41.1 fF, ratio 1.82, Q 21.9-30.6 at 20 GHz (Nx=10)
*
* From Q = 6.8:  Rs = wL/Q = 56.5/6.8 = 8.3 ohm differential.
* Tank Rp = Q*wL = 385 ohm, so startup needs gm > 2/Rp = 5.2 mS.
* At 4x margin that is gm = 20.8 mS, i.e. Ic = gm*VT = only 0.54 mA per device.
*
* The bias here is 1.5 mA per device anyway — roughly 11x the startup
* requirement. Startup margin is not the binding constraint; amplitude is.
* Phase noise falls as signal power rises, and with tank Q only 5.6 the design
* needs every dB of swing it can get. 1.5 mA also sits close to peak fT
* (measured at 1.8 mA) and well below the 4 mA high-injection cliff, so the
* current is nearly free. If the swing clips hard against the supply, back the
* tail current off rather than adding margin that is not needed.
*
* SECOND PASS: the varactor is now in the tank and Vtune is swept.
*
* The first pass ran with a 40 fF fixed cap and oscillated at 32.05 GHz. Since
* 32.05 GHz on 0.45 nH needs 54.8 fF of total tank capacitance, the devices
* themselves contribute about 15 fF of Cbe + Cbc. That was a measurement, not
* an assumption, and it is what makes the budget below trustworthy: at 126 fF
* fixed the circuit landed on 20.05 GHz, confirming it.
*
* Capacitance budget for a 20 GHz centre:
*   total needed          141 fF
*   devices (measured)    -15 fF
*   varactor (22.6-41.1)  -32 fF average
*   fixed cap              =94 fF
*
* Predicted: 19.36-20.68 GHz, about 6.6% tuning. Whether the real circuit
* agrees is the point of this run.

.lib /foss/pdks/ihp-sg13g2/libs.tech/ngspice/models/cornerHBT.lib hbt_typ
.lib /foss/pdks/ihp-sg13g2/libs.tech/ngspice/models/cornerMOShv.lib mos_tt

.param vcc  = 3.3
.param cfix = 94f
.param vtune = 1.65
.param itail = 3m

VCC vcc 0 DC {vcc}

* ---------------- tank ----------------
* The 0.45 nH is the DIFFERENTIAL inductance, so each half is 0.225 nH and
* each half carries half the series loss. Centre tap feeds the supply.
L1 vcc n1 0.225n
R1 n1  outp 4.15
L2 vcc n2 0.225n
R2 n2  outn 4.15

* Fixed tank capacitance. RF MIM would be the real component; an ideal cap
* here keeps this run about the varactor alone.
CT outp outn {cfix}

* ---------------- varactor ----------------
* sg13_hv_svaricap pins: G1 W G2 bn
* Both gates sit at Vcc (3.3 V) through the inductor, and the well is driven by
* Vtune, so the varactor sees Vg - Vw = 3.3 - vtune. Sweeping vtune from 0 to
* 3.3 V therefore walks the C-V curve from +3.3 V down to 0 V of gate-well
* bias — the upper half of the characterised range, where C runs from roughly
* 41 fF down toward the middle of the S-curve.
XCV outp vt outn 0 sg13_hv_svaricap l=0.3u w=3.74u Nx=10 Ny=1 mm_ok=1

VTUNE vt 0 DC {vtune}

* ---------------- cross-coupled pair ----------------
* collector base emitter substrate — base of each device driven by the
* opposite collector, which is what produces the negative resistance.
XQ1 outp outn e 0 npn13G2 Nx=1 mm_ok=1
XQ2 outn outp e 0 npn13G2 Nx=1 mm_ok=1

* ---------------- tail bias ----------------
* Ideal current sink for now. A real mirror comes later; keeping it ideal here
* means any startup failure is the oscillator's fault, not the bias network's.
ITAIL e 0 DC {itail}

* Asymmetric initial condition to break the symmetry. A perfectly balanced
* oscillator sitting at its DC operating point has no reason to start; real
* ones are kicked by noise, simulators need telling.
.ic v(outp)=3.35 v(outn)=3.25

.control
  set noaskquit

  echo ""
  echo "  Cross-coupled LC VCO with varactor tuning, SG13G2"
  echo "  L = 0.45nH diff (Rs 8.3 ohm), Cfix = 94 fF, Itail = 3 mA"
  echo ""
  echo "   Vtune(V)   f(GHz)     swing(Vpp)"
  echo "   ---------------------------------"

  foreach vt 0.0 0.4 0.8 1.2 1.65 2.0 2.4 2.8 3.3
    alter VTUNE dc = $vt

    * 20 GHz is a 50 ps period; 0.2 ps steps give 250 points per cycle. 6 ns is
    * about 120 cycles, long enough for the amplitude to settle.
    tran 0.2p 6n

    let vdiff = v(outp) - v(outn)
    meas tran t1 WHEN vdiff=0 RISE=80
    meas tran t2 WHEN vdiff=0 RISE=90
    let fosc_ghz = 10/(t2-t1)/1e9

    meas tran vmax MAX vdiff FROM=4n TO=6n
    meas tran vmin MIN vdiff FROM=4n TO=6n
    let vpp = vmax - vmin

    echo "   $vt      $&fosc_ghz    $&vpp"
    destroy tran1
  end

  echo ""
  echo "  Tuning range is the spread of the frequency column. Note whether the"
  echo "  swing changes across it — varactor Q falls as C rises (measured 30.6"
  echo "  at Cmin, 21.9 at Cmax), so the low-frequency end has the lossier tank"
  echo "  and should show slightly less amplitude."
  echo ""

  alter VTUNE dc = 1.65
  tran 0.2p 6n
  let vdiff = v(outp) - v(outn)
  write vco_tuned.raw vdiff v(outp) v(outn)
  echo "  Wrote vco_tuned.raw at Vtune = 1.65 V.   plot vdiff"
.endc

.end
