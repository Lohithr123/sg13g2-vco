* Corner and temperature verification — 20 GHz VCO, IHP SG13G2
*
* A design verified only at typical is not verified. This sweeps the process
* corners the PDK ships and the industrial temperature range, and reports
* whether the oscillator still starts, where the frequency lands, and how much
* amplitude survives.
*
* WHAT THE HBT WORST CASE ACTUALLY DOES (from cornerHBT.lib, hbt_wcs):
*   vbic_re   1.27   emitter resistance +27%  -> degenerates gm, threatens startup
*   vbic_ibei 1.33   base current +33%        -> beta down by a third
*   vbic_tf   1.11   transit time +11%        -> fT down ~10%
*   vbic_cje  1.17   junction cap +17%        -> loads the tank, frequency down
*   vbic_is   0.74   saturation current -26%
*
* re and ibei are the ones that matter here. Higher emitter resistance directly
* degenerates transconductance, so effective gm falls well below the 20.8 mS
* the design was sized for. At typical there is roughly 11x startup margin, so
* it should survive — but "should" is what this run exists to replace.
*
* Expect the worst-case frequency a few hundred MHz below typical, because
* cje adds to the tank capacitance.
*
* CORNERS RUN
*   1  typ / tt   reference
*   2  wcs / ss   worst case: lowest gm, lossiest switches. Startup dies here
*                 first if the margin is thin.
*   3  bcs / ff   fastest: highest frequency, check for supply clipping
*   4  wcs / ff   slow devices, fast switches
*   5  bcs / ss   fast devices, lossy switches
*
* Temperature is swept separately on the worst electrical corner, because
* -40 C raises gm (good for startup) but shifts the tank, and +125 C does the
* opposite. Both ends need checking.
*
* Corners are selected by editing the .lib lines below and re-running. ngspice
* resolves .lib at parse time, so a single netlist cannot sweep them in one
* pass — hence the CORNER parameter block, changed per run.

* ---- SET THE CORNER HERE ----
.lib /foss/pdks/ihp-sg13g2/libs.tech/ngspice/models/cornerHBT.lib hbt_typ
.lib /foss/pdks/ihp-sg13g2/libs.tech/ngspice/models/cornerMOSlv.lib mos_tt
.lib /foss/pdks/ihp-sg13g2/libs.tech/ngspice/models/cornerMOShv.lib mos_tt

.param vcc    = 3.3
.param itail  = 2m
.param cfix   = 36f
.param vtune  = 1.65
.param vgbias = 1.65
.param cc     = 4p
.param rbias  = 10k
.param wsw    = 4u
.param clsb   = 2.08f

.param b0 = 0
.param b1 = 0
.param b2 = 0
.param b3 = 0

VCC vcc 0 DC {vcc}

L1 vcc n1 0.45n
R1 n1  outp 5.85
L2 vcc n2 0.45n
R2 n2  outn 5.85

CT outp outn {cfix}

CC1 outp gp {cc}
CC2 outn gn {cc}
RB1 gp vg {rbias}
RB2 gn vg {rbias}
VGB vg 0 DC {vgbias}
XCV gp vt gn 0 sg13_hv_svaricap l=0.3u w=3.74u Nx=2 Ny=1 mm_ok=1
VTUNE vt 0 DC {vtune}

CB0A outp s0a {2*clsb}
CB0B outn s0b {2*clsb}
XSW0 s0a nb0 s0b 0 sg13_lv_nmos w={wsw} l=0.13u ng=1 m=1
CB1A outp s1a {4*clsb}
CB1B outn s1b {4*clsb}
XSW1 s1a nb1 s1b 0 sg13_lv_nmos w={2*wsw} l=0.13u ng=1 m=1
CB2A outp s2a {8*clsb}
CB2B outn s2b {8*clsb}
XSW2 s2a nb2 s2b 0 sg13_lv_nmos w={4*wsw} l=0.13u ng=1 m=1
CB3A outp s3a {16*clsb}
CB3B outn s3b {16*clsb}
XSW3 s3a nb3 s3b 0 sg13_lv_nmos w={8*wsw} l=0.13u ng=1 m=1

VB0 nb0 0 DC {b0}
VB1 nb1 0 DC {b1}
VB2 nb2 0 DC {b2}
VB3 nb3 0 DC {b3}

RBL0A s0a 0 100k
RBL0B s0b 0 100k
RBL1A s1a 0 100k
RBL1B s1b 0 100k
RBL2A s2a 0 100k
RBL2B s2b 0 100k
RBL3A s3a 0 100k
RBL3B s3b 0 100k

XQ1 outp outn e 0 npn13G2 Nx=1 mm_ok=1
XQ2 outn outp e 0 npn13G2 Nx=1 mm_ok=1

ITAIL e 0 DC {itail}

.ic v(outp)=3.35 v(outn)=3.25

.control
  set noaskquit

  echo ""
  echo "  Corner run — edit the .lib lines at the top to change corner"
  echo ""
  echo "   T(C)   code   f(GHz)     swing(Vpp)   startup"
  echo "   ------------------------------------------------"

  * -40 / 27 / 125 C at the band extremes. Code 0 is the highest frequency
  * (least tank capacitance) and code 15 the lowest, so between them they
  * bracket the design.
  foreach tc -40 27 125
    set temp = $tc
    option temp = $tc

    foreach code 0 15
      let c = $code
      let bit0 = c % 2
      let bit1 = floor(c/2) % 2
      let bit2 = floor(c/4) % 2
      let bit3 = floor(c/8) % 2
      alter VB0 dc = $&bit0 * 3.3
      alter VB1 dc = $&bit1 * 3.3
      alter VB2 dc = $&bit2 * 3.3
      alter VB3 dc = $&bit3 * 3.3
      alter VTUNE dc = 1.65

      tran 0.2p 8n

      let vd = v(outp) - v(outn)
      meas tran ta WHEN vd=0 RISE=100
      meas tran tb WHEN vd=0 RISE=110
      meas tran vx MAX vd FROM=6n TO=8n
      meas tran vn MIN vd FROM=6n TO=8n
      destroy tran1
    end
  end

  echo ""
  echo "  Frequency = 10/(tb-ta), amplitude = vx-vn, for each (T, code) pair"
  echo "  in the order printed above: -40/0, -40/15, 27/0, 27/15, 125/0, 125/15."
  echo ""
  echo "  STARTUP CHECK: if a meas fails or the swing collapses below about"
  echo "  0.2 Vpp, the oscillator did not start at that corner. On hbt_wcs the"
  echo "  emitter resistance is 27% higher, so that is where to look first."
  echo ""
.endc

.end
