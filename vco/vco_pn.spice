* Phase noise — cross-coupled LC VCO, 0.9 nH tank, IHP SG13G2
*
* Design under test (all values measured earlier in this project):
*   inductor   0.901 nH differential, Q 9.68 at 20 GHz, SRF above 40 GHz
*              (Palace FEM: N=2, w=6um, s=3um, do=109.58um)
*              -> Rs = wL/Q = 11.70 ohm diff, 5.85 per half; Rp = 1096 ohm
*   npn13G2    peak fT 415 GHz at Ic ~1.8 mA; biased at 1 mA per device here
*   varactor   Nx=2, from the Nx=10 characterisation (22.6-41.1 fF, Q 21.9-30.6)
*   bank       4-bit, LSB 2.08 fF, 4 um switches, set to code 8 (mid band)
*   measured   18.17-20.55 GHz continuous, 1.66-1.76 Vpp, 6.6 mW
*
* METHOD AND ITS LIMITS
* ngspice has no harmonic-balance pnoise, so this is transient plus FFT: run
* long after startup, FFT the differential output, and read the skirt either
* side of the carrier.
*
* Frequency resolution is 1/T, so a 50 us run gives 20 kHz bins — enough for
* offsets from ~100 kHz upward. Going closer in means a longer run and much
* more memory; 50 us at 0.5 ps is already 100k points.
*
* What this does NOT capture well: the absolute noise floor depends on how the
* device models inject noise into a transient analysis, and the FFT's own floor
* limits how far down the skirt can be resolved. Treat the SHAPE as the result
* — -20 dB/decade through the 1/f^2 region is what Leeson predicts, and if the
* slope matches, the mechanism is right. The absolute number should be quoted
* as indicative and cross-checked against the Leeson estimate, not presented as
* a measured spec.

.lib /foss/pdks/ihp-sg13g2/libs.tech/ngspice/models/cornerHBT.lib hbt_typ
.lib /foss/pdks/ihp-sg13g2/libs.tech/ngspice/models/cornerMOSlv.lib mos_tt
.lib /foss/pdks/ihp-sg13g2/libs.tech/ngspice/models/cornerMOShv.lib mos_tt

.param vcc    = 3.3
.param itail  = 2m
.param cfix   = 36f
.param vtune  = 1.65
.param vgbias = 1.65
.param cc     = 4p
.param rbias  = 10k
.param wsw    = 4u
.param clsb   = 2.08f

* code 8 — middle of the bank
.param b0 = 0
.param b1 = 0
.param b2 = 0
.param b3 = 3.3

VCC vcc 0 DC {vcc}

L1 vcc n1 0.45n
R1 n1  outp 5.85
L2 vcc n2 0.45n
R2 n2  outn 5.85

CT outp outn {cfix}

CC1 outp gp {cc}
CC2 outn gn {cc}
RB1 gp vg {rbias}
RB2 gn vg {rbias}
VGB vg 0 DC {vgbias}
XCV gp vt gn 0 sg13_hv_svaricap l=0.3u w=3.74u Nx=2 Ny=1 mm_ok=1
VTUNE vt 0 DC {vtune}

CB0A outp s0a {2*clsb}
CB0B outn s0b {2*clsb}
XSW0 s0a nb0 s0b 0 sg13_lv_nmos w={wsw} l=0.13u ng=1 m=1
CB1A outp s1a {4*clsb}
CB1B outn s1b {4*clsb}
XSW1 s1a nb1 s1b 0 sg13_lv_nmos w={2*wsw} l=0.13u ng=1 m=1
CB2A outp s2a {8*clsb}
CB2B outn s2b {8*clsb}
XSW2 s2a nb2 s2b 0 sg13_lv_nmos w={4*wsw} l=0.13u ng=1 m=1
CB3A outp s3a {16*clsb}
CB3B outn s3b {16*clsb}
XSW3 s3a nb3 s3b 0 sg13_lv_nmos w={8*wsw} l=0.13u ng=1 m=1

VB0 nb0 0 DC {b0}
VB1 nb1 0 DC {b1}
VB2 nb2 0 DC {b2}
VB3 nb3 0 DC {b3}

RBL0A s0a 0 100k
RBL0B s0b 0 100k
RBL1A s1a 0 100k
RBL1B s1b 0 100k
RBL2A s2a 0 100k
RBL2B s2b 0 100k
RBL3A s3a 0 100k
RBL3B s3b 0 100k

XQ1 outp outn e 0 npn13G2 Nx=1 mm_ok=1
XQ2 outn outp e 0 npn13G2 Nx=1 mm_ok=1

ITAIL e 0 DC {itail}

.ic v(outp)=3.35 v(outn)=3.25

.control
  set noaskquit
  save outp outn

  echo ""
  echo "  Phase noise, 0.9 nH tank, code 8"
  echo "  Long run — several minutes."
  echo ""

  * Settle first. FFT-ing through startup would smear the carrier and bury the
  * skirt under the transient.
  * 50 us -> 20 kHz bins. uic continues from the settled state.
  tran 2p 15u 1n

  let vd = v(outp) - v(outn)

  meas tran ta WHEN vd=0 RISE=900
  meas tran tb WHEN vd=0 RISE=910
  let f0 = 10/(tb-ta)
  let f0g = f0/1e9
  meas tran vpk MAX vd FROM=13u TO=15u

  echo ""
  echo "  carrier    $&f0g GHz"
  echo "  amplitude  $&vpk V peak"
  echo ""

  * Hann window suppresses leakage; without it the carrier's own sidelobes
  * swamp everything within a few hundred kHz.
  set specwindow=hanning
  fft vd
  let m = db(mag(vd))

  * L(f) is the skirt power in 1 Hz relative to the carrier, so subtract
  * 10log10(bin width).
  let bw = 1/15e-6
  let corr = db(bw)

  echo "  offset       L(f) dBc/Hz"
  echo "  --------------------------"
  meas ac pk FIND m AT=f0
  foreach off 1e5 2e5 5e5 1e6 2e6 5e6 1e7
    let ft = f0 + $off
    meas ac sk FIND m AT=ft
    let pn = sk - pk - corr
    let ok = $off/1e3
    echo "  $&ok kHz      $&pn"
  end

  echo ""
  echo "  Check the slope: -20 dB/decade from 100 kHz to 1 MHz is the 1/f^2"
  echo "  region. Leeson with Q=9.68, Rp=1096 ohm, 1.7 Vpp predicts roughly"
  echo "  -85 dBc/Hz at 100 kHz and -105 at 1 MHz."
  echo ""

  write vco_pn.raw vd
.endc

.end
